* tx_cell: last 2:1 stages and output driver of one TX lane
* Generated by design/gen_cells.py; do not edit by hand.
.subckt tx_cell tx_a[0] tx_a[1] tx_b[0] tx_b[1] sel1 sel2 pad VDD VSS
N1 sel1b sel1 VSS VSS nmos_rvt L=20n NFIN=3
N2 sel1b sel1 VDD VDD pmos_rvt L=20n NFIN=3
N3 sel2b sel2 VSS VSS nmos_rvt L=20n NFIN=3
N4 sel2b sel2 VDD VDD pmos_rvt L=20n NFIN=3
N5 sa sel1b tx_a[0] VSS nmos_rvt L=20n NFIN=3
N6 sa sel1 tx_a[0] VDD pmos_rvt L=20n NFIN=3
N7 sa sel1 tx_a[1] VSS nmos_rvt L=20n NFIN=3
N8 sa sel1b tx_a[1] VDD pmos_rvt L=20n NFIN=3
N9 sb sel1b tx_b[0] VSS nmos_rvt L=20n NFIN=3
N10 sb sel1 tx_b[0] VDD pmos_rvt L=20n NFIN=3
N11 sb sel1 tx_b[1] VSS nmos_rvt L=20n NFIN=3
N12 sb sel1b tx_b[1] VDD pmos_rvt L=20n NFIN=3
N13 m sel2b sa VSS nmos_rvt L=20n NFIN=3
N14 m sel2 sa VDD pmos_rvt L=20n NFIN=3
N15 m sel2 sb VSS nmos_rvt L=20n NFIN=3
N16 m sel2b sb VDD pmos_rvt L=20n NFIN=3
N17 d1 m VSS VSS nmos_rvt L=20n NFIN=3
N18 d1 m VDD VDD pmos_rvt L=20n NFIN=3
N19 d2 d1 VSS VSS nmos_rvt L=20n NFIN=6
N20 d2 d1 VDD VDD pmos_rvt L=20n NFIN=6
N21 pad d2 VSS VSS nmos_rvt L=20n NFIN=12
N22 pad d2 VDD VDD pmos_rvt L=20n NFIN=12
.ends
