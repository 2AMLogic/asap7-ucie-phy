* rx_cell: input stage and sampler of one RX lane
* Generated by design/gen_cells.py; do not edit by hand.
.subckt rx_cell pad ph[0] ph[1] ph[2] ph[3] rx_a[0] rx_a[1] rx_b[0] rx_b[1] VDD VSS
N1 i1 pad VSS VSS nmos_rvt L=20n NFIN=3
N2 i1 pad VDD VDD pmos_rvt L=20n NFIN=3
N3 i2 i1 VSS VSS nmos_rvt L=20n NFIN=6
N4 i2 i1 VDD VDD pmos_rvt L=20n NFIN=6
N5 phb0 ph[0] VSS VSS nmos_rvt L=20n NFIN=1
N6 phb0 ph[0] VDD VDD pmos_rvt L=20n NFIN=1
N7 s0_x ph[0] i2 VSS nmos_rvt L=20n NFIN=2
N8 s0_x phb0 i2 VDD pmos_rvt L=20n NFIN=2
N9 s0_xb s0_x VSS VSS nmos_rvt L=20n NFIN=2
N10 s0_xb s0_x VDD VDD pmos_rvt L=20n NFIN=2
N11 rx_a[0] s0_xb VSS VSS nmos_rvt L=20n NFIN=2
N12 rx_a[0] s0_xb VDD VDD pmos_rvt L=20n NFIN=2
N13 s0_xk s0_xb VSS VSS nmos_rvt L=20n NFIN=1
N14 s0_xk s0_xb VDD VDD pmos_rvt L=20n NFIN=1
N15 s0_x phb0 s0_xk VSS nmos_rvt L=20n NFIN=1
N16 s0_x ph[0] s0_xk VDD pmos_rvt L=20n NFIN=1
N17 phb1 ph[1] VSS VSS nmos_rvt L=20n NFIN=1
N18 phb1 ph[1] VDD VDD pmos_rvt L=20n NFIN=1
N19 s1_x ph[1] i2 VSS nmos_rvt L=20n NFIN=2
N20 s1_x phb1 i2 VDD pmos_rvt L=20n NFIN=2
N21 s1_xb s1_x VSS VSS nmos_rvt L=20n NFIN=2
N22 s1_xb s1_x VDD VDD pmos_rvt L=20n NFIN=2
N23 rx_b[0] s1_xb VSS VSS nmos_rvt L=20n NFIN=2
N24 rx_b[0] s1_xb VDD VDD pmos_rvt L=20n NFIN=2
N25 s1_xk s1_xb VSS VSS nmos_rvt L=20n NFIN=1
N26 s1_xk s1_xb VDD VDD pmos_rvt L=20n NFIN=1
N27 s1_x phb1 s1_xk VSS nmos_rvt L=20n NFIN=1
N28 s1_x ph[1] s1_xk VDD pmos_rvt L=20n NFIN=1
N29 phb2 ph[2] VSS VSS nmos_rvt L=20n NFIN=1
N30 phb2 ph[2] VDD VDD pmos_rvt L=20n NFIN=1
N31 s2_x ph[2] i2 VSS nmos_rvt L=20n NFIN=2
N32 s2_x phb2 i2 VDD pmos_rvt L=20n NFIN=2
N33 s2_xb s2_x VSS VSS nmos_rvt L=20n NFIN=2
N34 s2_xb s2_x VDD VDD pmos_rvt L=20n NFIN=2
N35 rx_a[1] s2_xb VSS VSS nmos_rvt L=20n NFIN=2
N36 rx_a[1] s2_xb VDD VDD pmos_rvt L=20n NFIN=2
N37 s2_xk s2_xb VSS VSS nmos_rvt L=20n NFIN=1
N38 s2_xk s2_xb VDD VDD pmos_rvt L=20n NFIN=1
N39 s2_x phb2 s2_xk VSS nmos_rvt L=20n NFIN=1
N40 s2_x ph[2] s2_xk VDD pmos_rvt L=20n NFIN=1
N41 phb3 ph[3] VSS VSS nmos_rvt L=20n NFIN=1
N42 phb3 ph[3] VDD VDD pmos_rvt L=20n NFIN=1
N43 s3_x ph[3] i2 VSS nmos_rvt L=20n NFIN=2
N44 s3_x phb3 i2 VDD pmos_rvt L=20n NFIN=2
N45 s3_xb s3_x VSS VSS nmos_rvt L=20n NFIN=2
N46 s3_xb s3_x VDD VDD pmos_rvt L=20n NFIN=2
N47 rx_b[1] s3_xb VSS VSS nmos_rvt L=20n NFIN=2
N48 rx_b[1] s3_xb VDD VDD pmos_rvt L=20n NFIN=2
N49 s3_xk s3_xb VSS VSS nmos_rvt L=20n NFIN=1
N50 s3_xk s3_xb VDD VDD pmos_rvt L=20n NFIN=1
N51 s3_x phb3 s3_xk VSS nmos_rvt L=20n NFIN=1
N52 s3_x ph[3] s3_xk VDD pmos_rvt L=20n NFIN=1
.ends
