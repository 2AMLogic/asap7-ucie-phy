* rx_cell: input stage and sampler of one RX lane
* Generated by design/gen_cells.py; do not edit by hand.
.subckt rx_cell pad ph[0] ph[1] ph[2] ph[3] rx_a[0] rx_a[1] rx_b[0] rx_b[1] VDD VSS
M1 i1 pad VSS VSS nmos_rvt l=20n w=81n nfin=3
M2 i1 pad VDD VDD pmos_rvt l=20n w=81n nfin=3
M3 i2 i1 VSS VSS nmos_rvt l=20n w=162n nfin=6
M4 i2 i1 VDD VDD pmos_rvt l=20n w=162n nfin=6
M5 phb0 ph[0] VSS VSS nmos_rvt l=20n w=27n nfin=1
M6 phb0 ph[0] VDD VDD pmos_rvt l=20n w=27n nfin=1
M7 s0_x ph[0] i2 VSS nmos_rvt l=20n w=54n nfin=2
M8 s0_x phb0 i2 VDD pmos_rvt l=20n w=54n nfin=2
M9 s0_xb s0_x VSS VSS nmos_rvt l=20n w=54n nfin=2
M10 s0_xb s0_x VDD VDD pmos_rvt l=20n w=54n nfin=2
M11 rx_a[0] s0_xb VSS VSS nmos_rvt l=20n w=54n nfin=2
M12 rx_a[0] s0_xb VDD VDD pmos_rvt l=20n w=54n nfin=2
M13 s0_xk s0_xb VSS VSS nmos_rvt l=20n w=27n nfin=1
M14 s0_xk s0_xb VDD VDD pmos_rvt l=20n w=27n nfin=1
M15 s0_x phb0 s0_xk VSS nmos_rvt l=20n w=27n nfin=1
M16 s0_x ph[0] s0_xk VDD pmos_rvt l=20n w=27n nfin=1
M17 phb1 ph[1] VSS VSS nmos_rvt l=20n w=27n nfin=1
M18 phb1 ph[1] VDD VDD pmos_rvt l=20n w=27n nfin=1
M19 s1_x ph[1] i2 VSS nmos_rvt l=20n w=54n nfin=2
M20 s1_x phb1 i2 VDD pmos_rvt l=20n w=54n nfin=2
M21 s1_xb s1_x VSS VSS nmos_rvt l=20n w=54n nfin=2
M22 s1_xb s1_x VDD VDD pmos_rvt l=20n w=54n nfin=2
M23 rx_b[0] s1_xb VSS VSS nmos_rvt l=20n w=54n nfin=2
M24 rx_b[0] s1_xb VDD VDD pmos_rvt l=20n w=54n nfin=2
M25 s1_xk s1_xb VSS VSS nmos_rvt l=20n w=27n nfin=1
M26 s1_xk s1_xb VDD VDD pmos_rvt l=20n w=27n nfin=1
M27 s1_x phb1 s1_xk VSS nmos_rvt l=20n w=27n nfin=1
M28 s1_x ph[1] s1_xk VDD pmos_rvt l=20n w=27n nfin=1
M29 phb2 ph[2] VSS VSS nmos_rvt l=20n w=27n nfin=1
M30 phb2 ph[2] VDD VDD pmos_rvt l=20n w=27n nfin=1
M31 s2_x ph[2] i2 VSS nmos_rvt l=20n w=54n nfin=2
M32 s2_x phb2 i2 VDD pmos_rvt l=20n w=54n nfin=2
M33 s2_xb s2_x VSS VSS nmos_rvt l=20n w=54n nfin=2
M34 s2_xb s2_x VDD VDD pmos_rvt l=20n w=54n nfin=2
M35 rx_a[1] s2_xb VSS VSS nmos_rvt l=20n w=54n nfin=2
M36 rx_a[1] s2_xb VDD VDD pmos_rvt l=20n w=54n nfin=2
M37 s2_xk s2_xb VSS VSS nmos_rvt l=20n w=27n nfin=1
M38 s2_xk s2_xb VDD VDD pmos_rvt l=20n w=27n nfin=1
M39 s2_x phb2 s2_xk VSS nmos_rvt l=20n w=27n nfin=1
M40 s2_x ph[2] s2_xk VDD pmos_rvt l=20n w=27n nfin=1
M41 phb3 ph[3] VSS VSS nmos_rvt l=20n w=27n nfin=1
M42 phb3 ph[3] VDD VDD pmos_rvt l=20n w=27n nfin=1
M43 s3_x ph[3] i2 VSS nmos_rvt l=20n w=54n nfin=2
M44 s3_x phb3 i2 VDD pmos_rvt l=20n w=54n nfin=2
M45 s3_xb s3_x VSS VSS nmos_rvt l=20n w=54n nfin=2
M46 s3_xb s3_x VDD VDD pmos_rvt l=20n w=54n nfin=2
M47 rx_b[1] s3_xb VSS VSS nmos_rvt l=20n w=54n nfin=2
M48 rx_b[1] s3_xb VDD VDD pmos_rvt l=20n w=54n nfin=2
M49 s3_xk s3_xb VSS VSS nmos_rvt l=20n w=27n nfin=1
M50 s3_xk s3_xb VDD VDD pmos_rvt l=20n w=27n nfin=1
M51 s3_x phb3 s3_xk VSS nmos_rvt l=20n w=27n nfin=1
M52 s3_x ph[3] s3_xk VDD pmos_rvt l=20n w=27n nfin=1
.ends
