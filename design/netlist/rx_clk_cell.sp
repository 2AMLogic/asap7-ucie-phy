* rx_clk_cell: forwarded-clock lane: input stage to rx_clk
* Generated by design/gen_cells.py; do not edit by hand.
.subckt rx_clk_cell pad rx_clk VDD VSS
M1 i1 pad VSS VSS nmos_rvt l=20n w=81n nfin=3
M2 i1 pad VDD VDD pmos_rvt l=20n w=81n nfin=3
M3 i2 i1 VSS VSS nmos_rvt l=20n w=162n nfin=6
M4 i2 i1 VDD VDD pmos_rvt l=20n w=162n nfin=6
M5 i3 i2 VSS VSS nmos_rvt l=20n w=162n nfin=6
M6 i3 i2 VDD VDD pmos_rvt l=20n w=162n nfin=6
M7 rx_clk i3 VSS VSS nmos_rvt l=20n w=324n nfin=12
M8 rx_clk i3 VDD VDD pmos_rvt l=20n w=324n nfin=12
.ends
