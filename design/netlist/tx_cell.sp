* tx_cell: last 2:1 stages and output driver of one TX lane
* Generated by design/gen_cells.py; do not edit by hand.
.subckt tx_cell tx_a[0] tx_a[1] tx_b[0] tx_b[1] sel1 sel2 pad VDD VSS
M1 sel1b sel1 VSS VSS nmos_rvt l=20n w=81n nfin=3
M2 sel1b sel1 VDD VDD pmos_rvt l=20n w=81n nfin=3
M3 sel2b sel2 VSS VSS nmos_rvt l=20n w=81n nfin=3
M4 sel2b sel2 VDD VDD pmos_rvt l=20n w=81n nfin=3
M5 sa sel1b tx_a[0] VSS nmos_rvt l=20n w=81n nfin=3
M6 sa sel1 tx_a[0] VDD pmos_rvt l=20n w=81n nfin=3
M7 sa sel1 tx_a[1] VSS nmos_rvt l=20n w=81n nfin=3
M8 sa sel1b tx_a[1] VDD pmos_rvt l=20n w=81n nfin=3
M9 sb sel1b tx_b[0] VSS nmos_rvt l=20n w=81n nfin=3
M10 sb sel1 tx_b[0] VDD pmos_rvt l=20n w=81n nfin=3
M11 sb sel1 tx_b[1] VSS nmos_rvt l=20n w=81n nfin=3
M12 sb sel1b tx_b[1] VDD pmos_rvt l=20n w=81n nfin=3
M13 m sel2b sa VSS nmos_rvt l=20n w=81n nfin=3
M14 m sel2 sa VDD pmos_rvt l=20n w=81n nfin=3
M15 m sel2 sb VSS nmos_rvt l=20n w=81n nfin=3
M16 m sel2b sb VDD pmos_rvt l=20n w=81n nfin=3
M17 d1 m VSS VSS nmos_rvt l=20n w=81n nfin=3
M18 d1 m VDD VDD pmos_rvt l=20n w=81n nfin=3
M19 d2 d1 VSS VSS nmos_rvt l=20n w=162n nfin=6
M20 d2 d1 VDD VDD pmos_rvt l=20n w=162n nfin=6
M21 pad d2 VSS VSS nmos_rvt l=20n w=324n nfin=12
M22 pad d2 VDD VDD pmos_rvt l=20n w=324n nfin=12
.ends
