* tx_clk_cell: forwarded-clock lane: gate (tx_fwd_en) and driver
* Generated by design/gen_cells.py; do not edit by hand.
.subckt tx_clk_cell clk fwd_en pad VDD VSS
M1 g clk n0 VSS nmos_rvt l=20n w=81n nfin=3
M2 n0 fwd_en VSS VSS nmos_rvt l=20n w=81n nfin=3
M3 g clk VDD VDD pmos_rvt l=20n w=81n nfin=3
M4 g fwd_en VDD VDD pmos_rvt l=20n w=81n nfin=3
M5 d1 g VSS VSS nmos_rvt l=20n w=81n nfin=3
M6 d1 g VDD VDD pmos_rvt l=20n w=81n nfin=3
M7 d2 d1 VSS VSS nmos_rvt l=20n w=162n nfin=6
M8 d2 d1 VDD VDD pmos_rvt l=20n w=162n nfin=6
M9 pad d2 VSS VSS nmos_rvt l=20n w=324n nfin=12
M10 pad d2 VDD VDD pmos_rvt l=20n w=324n nfin=12
.ends
